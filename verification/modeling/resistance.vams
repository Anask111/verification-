`include "disciplines.vams"

module va_resistor(p,n) ;
parameter real resistance = 1000.0 ;
electrical p, n ;
analog
begin
if (resistance!=0.0)begin
I(p,n) <+ V(p,n)*resistance ;
$strobe("p = %g | n = %g", V(p), V(n));end
else
V(p,n) <+ 0.0 ;
end
endmodule
