`include "disciplines.vams"
`include "dcu.sv"

 module top (clk, rst_n, en, vdig,data, wrb,dvs_done_dig,dvs_data);

 input clk, rst_n, en;
  input vdig;
  wreal vdig;
  input [3:0] data;
  input wrb;
  output reg dvs_done_dig;
  output reg [31:0] dvs_data;

digital_18 d18 (
   clk, rst_n, en,vdig, data,wrb, dvs_done_dig,dvs_data);

endmodule
