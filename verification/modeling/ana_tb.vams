`include "disciplines.vams"

module ana_tb(clk);

output clk;
wreal clk;

reg temp;
assign clk=temp;
initial temp =0;
always temp=~temp;
initial #300 $finish;
endmodule
