`include "disciplines.vams"

module nid (in,out,smpl,en);

parameter real thresh = 2.5;
parameter integer dir = -1;// from [-1:+1] exclude 0;

output out ;
input in , smpl, en ;
electrical in , out , smpl ;

real state ;

analog begin
@(cross(V(smpl)-thresh,0)) begin
state = V(in); end
V(out) <+ transition(state, 0 , 10n);
end
endmodule
