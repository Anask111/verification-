`include "disciplines.vams"
`include "resistor.vams"

module tb ;
real
