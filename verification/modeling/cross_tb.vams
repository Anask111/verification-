`include "disciplines.vams"
`include "cross.vams"

module tb ;

parameter real thresh = 2.5;
parameter integer dir = -1;

electrical in , out , smpl;
reg en ;

nid #(thresh , dir) nd(.in(in), .out(out),.smpl(smpl),.en(en));

real in_val , smpl_val, out_val;

initial begin
en = 1;

smpl_val = 1;
#5
smpl_val = 1.5;
#5
smpl_val = 2.3;
#5
smpl_val = 3.0;
#5
smpl_val = 3.5;
#5
smpl_val = 3;
#5
smpl_val = 2.5;
#100
smpl_val = 2.3;
#50
smpl_val = 1.0;
end

initial begin
in_val = 1.2;
#5
in_val = 2.2;
#5
in_val = 3.2;
#5
in_val = 4.2;
#5
in_val = 5.2;
#5
in_val = 6.2;
#5
in_val = 7.2;
#5
in_val = 8.2;
//#5
//in_val = 9.2;
//#5
//in_val = 10.2;
//#5
//in_val = 11.2;
//#5
//in_val = 12.2;
//#5
//in_val = 13.2;
//#5
//in_val = 14.2;
//#5
//in_val = 15.2;
//#5
//in_val = 16.2;
//#5
//in_val = 17.2;
//#5
//in_val = 18.2;
//#5
//in_val = 19.2;
//#5
//in_val = 20.2;
//#5
in_val = 21.2;
#5
in_val = 20.2;
#5
in_val = 19.2;
#5
in_val = 18.2;
#5
in_val = 17.2;
#5
in_val = 16.2;
#5
in_val = 15.2;
#5
in_val = 14.2;
#5
in_val = 13.2;
#5
in_val = 12.2;
#5
in_val = 11.2;
#5
in_val = 10.2;
#5
in_val = 9.2;
#5
in_val = 8.2;
#5
in_val = 7.2;
#5
in_val = 6.2;
#5
in_val = 5.2;
#5
in_val = 4.2;
#5
in_val = 3.2;
#5
in_val = 2.2;
#5
in_val = 1.2;
end

analog begin
//en = 1'b1;
 V(smpl) <+ smpl_val;
V(in) <+ in_val;
end

/*integer i;

analog begin

V(in) <+ 0.0;
V(smpl) <+ 0.0;
en = 1'b1;

@(initial_step)begin
en = 1'b1;
V(in) <+ 1.0;
V(smpl) <+ -1.0;

for (i = 0; i<10 ; i = i+1)begin
V(smpl) <+ V(smpl) + 0.2;
end

V(in) <+ 2.0;
V(smpl) <+ -1.0;

for(i = 0 ; i<10 ; i = i+1)begin
V(smpl) <+ V(smpl) + 0.2;
end

en = 1'b0;

end
end */

initial begin
$monitor("time: %0t | in :%02.f | smpl: %0.2f | out: %0.2f |en :%b",$time, V(in),V(smpl),V(out),en);
end

endmodule
