`include "disciplines.vams"
`include "dvs_buck.vams"

module dvs_tb();

reg [7:0]dvs_data;
wire dvs_done;
//wire fb;
electrical fb;

parameter real factor = 0.06;

dvs_buck dut(dvs_data,
  dvs_done,
  fb);

initial begin
dvs_data = 'b0;
repeat(10) begin
#5 dvs_data = dvs_data+1;
end
end

endmodule
