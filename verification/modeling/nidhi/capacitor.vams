`include "disciplines.vams"

module capacitor(p,n);

inout p,n;
electrical p,n ;

parameter real C = 1.0;

analog begin
I(p,n) <+ C*ddt(V(p,n));
end

endmodule
