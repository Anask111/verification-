`include "disciplines.vams"
`include "constants.vams"

module voltage_divider(vin , vout);

input  vin;
output vout;
electrical vin,vout;

parameter real R1 = 5.0;
parameter real R2 = 5.0;

analog begin
V(vout) <+ V(vin)/R1+R2*R2;
end

endmodule
