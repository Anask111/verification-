`include "disciplines.vams"
`include "temp_sensor.vams"
module tb;
wreal vin;
wire w1,w2,w3;
real temp;

prac p1(vin,w1,w2,w3);
assign vin = temp;
initial begin
temp =0;
#3 temp = 1.1;
#3 temp = 2.1;
#5 temp = 2.5;
#5 temp = 3.1;
#5 temp = 4.5;
end
/*
always #1 begin
temp = temp + 0.1;
end
*/
initial #1000 $finish;

endmodule
