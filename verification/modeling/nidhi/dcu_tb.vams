`include "dcu.vams"
`include "disciplines.vams"

module tb ;

  reg clk, rst_n, en;
  real vdig;
  reg [3:0] data;
  reg wrb;

 wire dvs_done_dig;
  wreal dvs_data;

digital_18 d18( clk, rst_n, en,vdig,data,wrb,dvs_done_dig,dvs_data);

always #5 clk = ~clk ;

initial begin
clk = 0;
rst_n = 0;
vdig = 0;
data = 0;
wrb = 0;
en = 0;
end

initial begin
#5
en =  1;
rst_n = 1;
vdig = 1.6;
#5
data = 4'b0001;
#2000
data = 4'b1000;
#5000
$finish;
end

endmodule
