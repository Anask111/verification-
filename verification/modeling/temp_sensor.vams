`include "disciplines.vams"
module prac(Vin,w1,w2,w3);
input Vin;
output w1,w2,w3;
wreal Vin;

assign w1 = (Vin>2.5)?1:0;
assign w2 = (Vin>3.5)?1:0;
assign w3 = (Vin>5.0)?1:0;
endmodule
