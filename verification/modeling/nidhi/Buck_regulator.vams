`include "disciplines.vams"
`include "dvs_buck.vams"
`include "dcu.vams"
`include "buck_monitor.vams"

module buck_top(clk,rst_n, en , wrb ,vdig, data,vdd,vss,vana,vref,V2,ov , uv );

// DCU signals
input clk , rst_n, en ;
input wreal vdig ;
input [3:0]data;
input wrb ;
input real V2;

// DVS signals
input wreal vdd , vss , vana, vref ;
//output wire dvs_done;

// INTERNAL VARIABLES
wreal dvs_data ;
wire dvs_done_dig;
wire dvs_done_ana;
//wire dvs_done;
real fb , lx ;
wire dvs_done ;

//DCU block
digital_18 d18 (.clk(clk), .rst_n(rst_n), .en(en), .vdig(vdig),.data(data), .wrb(wrb),.dvs_done_dig(dvs_done_dig),.dvs_data(dvs_data));

//DVS BLOCK
dvs_buck  db (.en(en),.vdd(vdd),.vss(vss),.vana(vana),.vref(vref),.dvs_data(dvs_data),.fb(fb),.lx(lx),.dvs_done_ana(dvs_done_ana));

//MONITOR
monitor B_mon (.dvs_done(dvs_done) , .vdd(vdd), .vss(vss) , .vref(vref) ,.vana( vana) ,.V1(fb) , .V2(V2) , .ov(ov) , .uv(uv));

assign dvs_done = dvs_done_dig && dvs_done_ana ;

endmodule
