module mux_dut(out,inp,sel);
output wreal out;
input wreal inp[1:0];
input sel;

assign out = sel ? inp[0] : inp[1];

endmodule

module tb_mux;
wreal out;
wreal inp[1:0];
reg sel;

real t1,t2,t3;

mux_dut mux_tb(out ,inp ,sel);

assign inp[0]=t1;
assign inp[1]=t2;
//assign sel =t3;
initial begin

#5 t1=1.1;
#5 t2=1.1;
#5 sel =0;

#5 t1=1.1;
#5 t2=1.1;
#5 sel =1;

#500 $finish;
end
endmodule
