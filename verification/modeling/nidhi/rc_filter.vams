`include "disciplines.vams"
`include "resistor.vams"
`include "capacitor.vams"
//`include"constants.vams"

module rc_filter(v1, v2, vout);

input v1, v2;
output vout;
electrical v1, v2, vout;

//electrical mid;

//parameter real gnd = 0.0;
parameter real Rf = 10.0;
parameter real Cf = 1e-6;

resistor  reg1 (.p(v2), .n(vout));
//defparam reg1.R = Rf;

capacitor Cap1 (.p(v1), .n(v2));
//defparam Cap1.C = Cf;

analog begin
V(vout) <+ V(v2);
end
endmodule
