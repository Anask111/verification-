`include "disciplines.vams"

module comparator(a0,a1,a2,a3, b0,b1,b2,b3 , out );

input wreal a0,a1,a2,a3 , b0,b1,b2,b3 ;
output wreal out ;

wreal out1, out2 , s1,s0;

assign out1 = s1 ? (s0? a3:a2) : (s0 ? a1:a0);
assign out2 = s1 ? (s0? b3:b2) : (s0 ? b1:b0);
assign out = (out1 > out2) ? out1 : out2;

endmodule
